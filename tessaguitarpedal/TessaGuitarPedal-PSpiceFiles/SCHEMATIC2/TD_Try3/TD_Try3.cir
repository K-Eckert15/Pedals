** Profile: "SCHEMATIC2-TD_Try3"  [ C:\USERS\KYLES\DOCUMENTS\GITHUB\PEDALS\TESSAGUITARPEDAL\TESSAGUITARPEDAL-PSpiceFiles\SCHEMATIC2\TD_Try3.sim ]

** Creating circuit file "TD_Try3.cir"
** WARNING: THIS AUTOMATICALLY GENERATED FILE MAY BE OVERWRITTEN BY SUBSEQUENT SIMULATIONS

*Libraries:
* Profile Libraries :
* Local Libraries :
.LIB "../../../tessaguitarpedal-pspicefiles/tessaguitarpedal.lib"
* From [PSPICE NETLIST] section of C:\Users\kyles\AppData\Roaming\SPB_Data\cdssetup\OrCAD_PSpice\25.1.0\PSpice.ini file:
.lib "nom.lib"

*Analysis directives:
.TRAN  0 1m 0
.OPTIONS ADVCONV
.PROBE64 V(alias(*)) I(alias(*)) W(alias(*)) D(alias(*)) NOISE(alias(*))
.INC "..\SCHEMATIC2.net"

.END
