** Profile: "SCHEMATIC1-TD_SIM"  [ C:\USERS\KYLES\DOCUMENTS\GITHUB\PEDALS\TESSAGUITARPEDAL\TESSAGUITARPEDAL-PSpiceFiles\SCHEMATIC1\TD_SIM.sim ]

** Creating circuit file "TD_SIM.cir"
** WARNING: THIS AUTOMATICALLY GENERATED FILE MAY BE OVERWRITTEN BY SUBSEQUENT SIMULATIONS

*Libraries:
* Profile Libraries :
* Local Libraries :
.LIB "../../../tessaguitarpedal-pspicefiles/tessaguitarpedal.lib"
* From [PSPICE NETLIST] section of C:\Users\kyles\AppData\Roaming\SPB_Data\cdssetup\OrCAD_PSpice\25.1.0\PSpice.ini file:
.lib "nom.lib"

*Analysis directives:
.TRAN  0 3m 0
.OPTIONS ADVCONV
.PROBE64 V(alias(*)) I(alias(*)) W(alias(*)) D(alias(*)) NOISE(alias(*))
.INC "..\SCHEMATIC1.net"

.END
