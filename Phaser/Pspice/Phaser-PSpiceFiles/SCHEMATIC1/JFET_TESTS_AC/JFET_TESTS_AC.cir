** Profile: "SCHEMATIC1-JFET_TESTS_AC"  [ c:\users\kyles\documents\github\pedals\phaser\pspice\phaser-PSpiceFiles\SCHEMATIC1\JFET_TESTS_AC.sim ]

** Creating circuit file "JFET_TESTS_AC.cir"
** WARNING: THIS AUTOMATICALLY GENERATED FILE MAY BE OVERWRITTEN BY SUBSEQUENT SIMULATIONS

*Libraries:
* Profile Libraries :
* Local Libraries :
* From [PSPICE NETLIST] section of C:\Users\kyles\AppData\Roaming\SPB_Data\cdssetup\OrCAD_PSpice\25.1.0\PSpice.ini file:
.lib "nom.lib"

*Analysis directives:
.AC DEC 100 100 20k
.OPTIONS ADVCONV
.PROBE64 V(alias(*)) I(alias(*)) W(alias(*)) D(alias(*)) NOISE(alias(*))
.INC "..\SCHEMATIC1.net"

.END
