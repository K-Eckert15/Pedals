** Profile: "SCHEMATIC1-JFET_TD"  [ c:\users\kyles\documents\github\pedals\phaser\pspice\phaser-PSpiceFiles\SCHEMATIC1\JFET_TD.sim ]

** Creating circuit file "JFET_TD.cir"
** WARNING: THIS AUTOMATICALLY GENERATED FILE MAY BE OVERWRITTEN BY SUBSEQUENT SIMULATIONS

*Libraries:
* Profile Libraries :
* Local Libraries :
* From [PSPICE NETLIST] section of C:\Users\kyles\AppData\Roaming\SPB_Data\cdssetup\OrCAD_PSpice\25.1.0\PSpice.ini file:
.lib "nom.lib"

*Analysis directives:
.TRAN  0 1.5 0 100m
.STEP LIN PARAM LFO_Bias 0 1 .3
.OPTIONS ADVCONV
.PROBE64 V(alias(*)) I(alias(*)) W(alias(*)) D(alias(*)) NOISE(alias(*))
.INC "..\SCHEMATIC1.net"

.END
